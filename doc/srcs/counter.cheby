memory-map:
  bus: wb-32-be
  name: counter
  description: A simple example of a counter
  children:
    - reg:
        name: control
        comment: Counter control
        description: This register controls the counter activity.
        width: 32
        access: rw
        children:
          - field:
              name: enable
              comment: Set to enable the counter
              description: >
                If the bit is set, the counter is running.

                If the bit is cleared, the counter is frozen.
              range: 0
    - reg:
        name: value
        description: Maximum value of the counter
        width: 32
        access: rw
    - reg:
        name: counter
        description: Current value of the counter
        width: 32
        access: ro
