memory-map:
  bus: wb-32-be
  name: led_demo
  description: simple interface to leds
  children:
    - repeat:
        name: leds
        count: 8
        children:
          - reg:
              name: led
              access: rw
              width: 32
              children:
                - field:
                    name: en
                    range: 0
